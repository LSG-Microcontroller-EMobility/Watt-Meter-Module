** Profile: "SCHEMATIC1-bias"  [ c:\repo\lsg-microcontroller-emobility\watt-meter-module\circuits\schematics\watts_meter_input_test-pspicefiles\schematic1\bias.sim ]

** Creating circuit file "bias.cir"
** WARNING: THIS AUTOMATICALLY GENERATED FILE MAY BE OVERWRITTEN BY SUBSEQUENT SIMULATIONS

*Libraries:
* Profile Libraries :
* Local Libraries :
.LIB "../../../watts_meter_input_test-PSpiceFiles/WATTS_METER_INPUT_TEST.lib"
* From [PSPICE NETLIST] section of C:\Users\luigi\AppData\Roaming\SPB_16.6\cdssetup\OrCAD_PSpice/16.6.0/PSpice.ini file:
.lib "nomd.lib"

*Analysis directives:
.TRAN  0 5 0 0.001
.OPTIONS ADVCONV
.PROBE64 V(alias(*)) I(alias(*)) W(alias(*)) D(alias(*)) NOISE(alias(*))
.INC "..\SCHEMATIC1.net"

.END
